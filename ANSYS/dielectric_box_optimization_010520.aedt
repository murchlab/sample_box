# Ansys Electronics Desktop project, version 2019.2
project datasets:
  $ds1: (100000000, 6.366) (1000000000, 6.33) (2000000000, 6.318) (3000000000, 6.312) (4000000000, 6.309) (5000000000, 6.307) (6000000000, 6.306) (7000000000, 6.305) (8000000000, 6.303) (9000000000, 6.302) (10000000000, 6.302) (11000000000, 6.301) (12000000000, 6.3) (13000000000, 6.299) (14000000000, 6.299) (15000000000, 6.298) (16000000000, 6.298) (17000000000, 6.297) (18000000000, 6.297) (19000000000, 6.296) (20000000000, 6.296) (21000000000, 6.295) (22000000000, 6.295) (23000000000, 6.294) (24000000000, 6.294) (25000000000, 6.294) (26000000000, 6.293) (27000000000, 6.293) (28000000000, 6.293) (29000000000, 6.293) (30000000000, 6.292) (31000000000, 6.292) (32000000000, 6.292) (33000000000, 6.291) (34000000000, 6.291) (35000000000, 6.291) (36000000000, 6.291) (37000000000, 6.29) (38000000000, 6.29) (39000000000, 6.29) (40000000000, 6.29) (41000000000, 6.29) (42000000000, 6.289) (43000000000, 6.289) (44000000000, 6.289) (45000000000, 6.289) (46000000000, 6.289) (47000000000, 6.288) (48000000000, 6.288) (49000000000, 6.288) (50000000000, 6.288) (51000000000, 6.288) (52000000000, 6.288) (53000000000, 6.287) (54000000000, 6.287) (55000000000, 6.287) (56000000000, 6.287) (57000000000, 6.287) (58000000000, 6.287) (59000000000, 6.286) (60000000000, 6.286) (61000000000, 6.286) (62000000000, 6.286) (63000000000, 6.286) (64000000000, 6.286) (65000000000, 6.286) (66000000000, 6.286) (67000000000, 6.285) (68000000000, 6.285) (69000000000, 6.285) (70000000000, 6.285) (71000000000, 6.285) (72000000000, 6.285) (73000000000, 6.285) (74000000000, 6.285) (75000000000, 6.284) (76000000000, 6.284) (77000000000, 6.284) (78000000000, 6.284) (79000000000, 6.284) (80000000000, 6.284) (81000000000, 6.284) (82000000000, 6.284) (83000000000, 6.284) (84000000000, 6.284) (85000000000, 6.283) (86000000000, 6.283) (87000000000, 6.283) (88000000000, 6.283) (89000000000, 6.283) (90000000000, 6.283) (91000000000, 6.283) (92000000000, 6.283) (93000000000, 6.283) (94000000000, 6.283) (95000000000, 6.282) (96000000000, 6.282) (97000000000, 6.282) (98000000000, 6.282) (99000000000, 6.282) (100000000000, 6.282) (101000000000, 6.282) (102000000000, 6.282) (103000000000, 6.282) (104000000000, 6.282) (105000000000, 6.282) (106000000000, 6.282) (107000000000, 6.281) (108000000000, 6.281) (109000000000, 6.281) (110000000000, 6.281)
materials:
  vacuum: permittivity=1
  Rogers TMM 6 (tm): permittivity=6 dielectric_loss_tangent=0.0023
  copper: permeability=0.999991 conductivity=58000000
  LD PTFE: permittivity=1.655 dielectric_loss_tangent=0.0002
  Rogers TMM 6 (tm) Calibrated: permittivity=pwl($ds1,Freq) dielectric_loss_tangent=0.0023

design HFSSDesign1 (HFSS, DrivenModal, model units in)
variables:
  dielectric_d = 0.96in
  dielectric_h = 0.05in
  copper_t = 27.4um
  W = 0.785mm
  G = 0.254mm
  io_r = 0.4in
  silicon_size = 8mm
  coaxial_inner_d = 0.0226in
  io_x = 0.093in
  post_r1 = 0.225in
  post_r2 = 0.295in
  post_hole_size = 0.093in
  transition_l = 2.019mm
  io_y = sqrt(io_r^2 - io_x^2)
  W2 = 1.1mm
  W3 = 700um  # optimise 0.25mm..0.75mm
  stub_x = -88um  # optimise 0.054375mm..0.163125mm
  stub_y = 2.7mm
  stub_theta = 31deg  # optimise 45deg..135deg
  stub_l = 1.1mm  # optimise 0.525mm..1.575mm
  G2 = 0.975mm  # optimise 0.355mm..1.065mm
  G3 = G
  stub_G1 = G
  stub_G2 = G
  inset = 0.03in
  coaxial_outer_d = 0.0865in
  via_d = 0.4mm
  transmission_r = ((io_x / 2 + silicon_size^2 / io_x / 8)*1000) mm
  box_w = 0.1in
  box_h = 0.19in
  post_d = 0.079in
  box_d = 0.971in
  cpw_l = io_y - (W2/2 + G2 + silicon_size/2)
  extrude = 0.01in
  coaxial_l = 0.25in
  coaxial_dielectric_d = 0.066in
  fillet = 127um
  edge_w = 0.01in
  via_gap = 0.45mm
  air_gap = 0in
  W4 = 0um
  fillet_r2 = 800um
  W5 = 725um
geometry:
  TMM6 [Rogers TMM 6 (tm) Calibrated] = cylinder(axis=Z, base_centre=(0in, 0in, 0in), radius=dielectric_d / 2, height=dielectric_h)
  Post_Holes = cylinder(axis=Z, base_centre=(0in, post_r1, -copper_t), radius=post_hole_size / 2, height=dielectric_h + 2*copper_t)
  Post2 = cylinder(axis=Z, base_centre=(post_r2 / sqrt(2), post_r2 / sqrt(2), -copper_t), radius=post_hole_size / 2, height=dielectric_h + 2*copper_t)
  Post1_1, Post1_2, Post1_3 = Post_Holes.duplicate_around_axis(axis=Z, angle=90deg, total=4)
  Post2_1, Post2_2, Post2_3 = Post2.duplicate_around_axis(axis=Z, angle=90deg, total=4)
  Post_Holes.unite(Post1_1, Post1_2, Post1_3, Post2, Post2_1, Post2_2, Post2_3)
  via_cpw_l_1 = cylinder(axis=Z, base_centre=(1.5mm, 11.5mm, 0in), radius=via_d / 2, height=dielectric_h)
  via_cpw_l_2 = cylinder(axis=Z, base_centre=(0.5mm, 10.5mm, 0in), radius=via_d / 2, height=dielectric_h)
  via_cpw_l_3 = cylinder(axis=Z, base_centre=(0.5mm, 9.5mm, 0in), radius=via_d / 2, height=dielectric_h)
  via_cpw_l_4 = cylinder(axis=Z, base_centre=(0.5mm, 8.5mm, 0in), radius=via_d / 2, height=dielectric_h)
  via_cpw_r = cylinder(axis=Z, base_centre=(4.25mm, 10.25mm, 0mm), radius=via_d / 2, height=dielectric_h)
  via_cpw_r_1 = cylinder(axis=Z, base_centre=(5.25mm, 10.25mm, 0mm), radius=via_d / 2, height=dielectric_h)
  via_cpw_r_2 = cylinder(axis=Z, base_centre=(4.25mm, 9.25mm, 0in), radius=via_d / 2, height=dielectric_h)
  via_cpw_r_3 = cylinder(axis=Z, base_centre=(5.25mm, 9.25mm, 0in), radius=via_d / 2, height=dielectric_h)
  via_cpw_r_4 = cylinder(axis=Z, base_centre=(6.25mm, 9.25mm, 0in), radius=via_d / 2, height=dielectric_h)
  via_cpw_r_5 = cylinder(axis=Z, base_centre=(7.25mm, 9.25mm, 0in), radius=via_d / 2, height=dielectric_h)
  via_cpw_r_6 = cylinder(axis=Z, base_centre=(4.25mm, 8.25mm, 0in), radius=via_d / 2, height=dielectric_h)
  via_cpw_r_7 = cylinder(axis=Z, base_centre=(5.25mm, 8.25mm, 0in), radius=via_d / 2, height=dielectric_h)
  via_cpw_r_8 = cylinder(axis=Z, base_centre=(6.25mm, 8.25mm, 0in), radius=via_d / 2, height=dielectric_h)
  Box [copper] = cylinder(axis=Z, base_centre=(0in, 0in, -copper_t - box_w), radius=box_d / 2 + box_w, height=box_h + 2 * box_w)
  Post [copper] = cylinder(axis=Z, base_centre=(0in, post_r1, -copper_t), radius=post_d / 2, height=box_h)
  Post5 = cylinder(axis=Z, base_centre=(post_r2 / sqrt(2), post_r2 / sqrt(2), -copper_t), radius=post_d / 2, height=box_h)
  Post_1, Post_2, Post_3 = Post.duplicate_around_axis(axis=Z, angle=90deg, total=4)
  Post5_1, Post5_2, Post5_3 = Post5.duplicate_around_axis(axis=Z, angle=90deg, total=4)
  Post.unite(Post_1, Post_2, Post_3, Post5, Post5_1, Post5_2, Post5_3)
  LD_PTFE [LD PTFE] = cylinder(axis=Z, base_centre=(io_x, io_y, -coaxial_l), radius=coaxial_dielectric_d / 2, height=coaxial_l + inset)
  Outer_Conductor [copper] = cylinder(axis=Z, base_centre=(io_x, io_y, -coaxial_l), radius=coaxial_outer_d / 2, height=coaxial_l + inset)
  Center_Conductor [copper] = cylinder(axis=Z, base_centre=(io_x, io_y, -coaxial_l), radius=coaxial_inner_d / 2, height=coaxial_l + dielectric_h + extrude)
  LD_PTFE_1 = LD_PTFE.copy()
  Outer_Conductor.subtract(LD_PTFE_1)
  Center_Conductor_1 = Center_Conductor.copy()
  LD_PTFE.subtract(Center_Conductor_1)
  Outer_Conductor_1 [copper] = Outer_Conductor.duplicate_around_axis(axis=Z, angle=180deg, total=2)
  Center_Conductor_2 [copper] = Center_Conductor.duplicate_around_axis(axis=Z, angle=180deg, total=2)
  LD_PTFE_2 [LD PTFE] = LD_PTFE.duplicate_around_axis(axis=Z, angle=180deg, total=2)
  Center_Conductor_3 = Center_Conductor.copy()
  Center_Conductor_2_1 = Center_Conductor_2.copy()
  LD_PTFE_3 = LD_PTFE.copy()
  LD_PTFE_2_1 = LD_PTFE_2.copy()
  Outer_Conductor_2 = Outer_Conductor.copy()
  Outer_Conductor_1_1 = Outer_Conductor_1.copy()
  Vacuum1 = cylinder(axis=Z, base_centre=(0in, 0in, -copper_t), radius=box_d / 2, height=box_h)
  Box.subtract(Vacuum1)
  Box.subtract(Center_Conductor_2_1, Center_Conductor_3, LD_PTFE_2_1, LD_PTFE_3, Outer_Conductor_1_1, Outer_Conductor_2)
  via_cpw_r_9 = cylinder(axis=Z, base_centre=(7.25mm, 8.25mm, 0in), radius=via_d / 2, height=dielectric_h)
  via_cpw_l = cylinder(axis=Z, base_centre=(0.5mm, 11.5mm, 0in), radius=via_d / 2, height=dielectric_h)
  via_cpw_l_11 = cylinder(axis=Z, base_centre=(io_x - (W/2 + G + via_gap), 4.8mm, 0in), radius=via_d / 2, height=dielectric_h)
  via_cpw_l_10 = cylinder(axis=Z, base_centre=(io_x - (W/2 + G + via_gap), 7mm, 0in), radius=via_d / 2, height=dielectric_h)
  via_cpw_t = cylinder(axis=Z, base_centre=(transmission_r + (W/2 + G + via_gap), 0mm, 0in), radius=via_d / 2, height=dielectric_h)
  via_cpw_t_1..via_cpw_t_4 = via_cpw_t.duplicate_around_axis(axis=Z, angle=-1mm/transmission_r/pi*180deg, total=5)
  via_cpw_t.unite(via_cpw_t_1..via_cpw_t_4)
  via_cpw_t.move(io_x-transmission_r, silicon_size/2, 0in)
  via_cpw_t1 = cylinder(axis=Z, base_centre=(transmission_r - (W/2 + G + via_gap), 0mm, 0in), radius=via_d / 2, height=dielectric_h)
  via_cpw_t1_1, via_cpw_t1_2, via_cpw_t1_3 = via_cpw_t1.duplicate_around_axis(axis=Z, angle=-20deg, total=4)
  via_cpw_t1.unite(via_cpw_t1_1, via_cpw_t1_2, via_cpw_t1_3)
  via_cpw_t1.move(io_x-transmission_r, silicon_size/2, 0in)
  via_cpw_t.unite(via_cpw_t1)
  via_cpw_t_5 = via_cpw_t.duplicate_around_axis(axis=Z, angle=180deg, total=2)
  via_cpw_t.unite(via_cpw_t_5)
  via_cpw_r_21 = cylinder(axis=Z, base_centre=(io_x + (W/2 + G + via_gap), 6mm, 0in), radius=via_d / 2, height=dielectric_h)
  [Box, Post].move(0in, 0in, -air_gap)
  TMM6.subtract(Post_Holes)
  Pocket [non-model] = rectangle(corner=(-silicon_size/2, -silicon_size/2, dielectric_h + copper_t), x_size=silicon_size, y_size=silicon_size)
  via_cpw_l_5 = cylinder(axis=Z, base_centre=(0.5mm, 7.5mm, 0in), radius=via_d / 2, height=dielectric_h)
  via_cpw_r_10 = cylinder(axis=Z, base_centre=(8.25mm, 8.25mm, 0in), radius=via_d / 2, height=dielectric_h)
  via_cpw_r_11 = cylinder(axis=Z, base_centre=(4.25mm, 7.25mm, 0in), radius=via_d / 2, height=dielectric_h)
  via_cpw_r_12 = cylinder(axis=Z, base_centre=(5.25mm, 7.25mm, 0in), radius=via_d / 2, height=dielectric_h)
  via_cpw_r_13 = cylinder(axis=Z, base_centre=(6.25mm, 7.25mm, 0in), radius=via_d / 2, height=dielectric_h)
  via_cpw_r_14 = cylinder(axis=Z, base_centre=(7.25mm, 7.25mm, 0in), radius=via_d / 2, height=dielectric_h)
  via_cpw_r_20 = cylinder(axis=Z, base_centre=(io_x + (W/2 + G + via_gap), 7mm, 0in), radius=via_d / 2, height=dielectric_h)
  Region [vacuum] = region(percentage_offset=0 on all sides)
  Center_Conductor_5 = Center_Conductor.copy()
  Center_Conductor_2_3 = Center_Conductor_2.copy()
  LD_PTFE_5 = LD_PTFE.copy()
  LD_PTFE_2_3 = LD_PTFE_2.copy()
  Outer_Conductor_4 = Outer_Conductor.copy()
  Outer_Conductor_1_3 = Outer_Conductor_1.copy()
  Gap = rectangle(corner=(W2/2 + G2 + stub_x, -W/2, dielectric_h), x_size=cpw_L - stub_x, y_size=W)
  Center = rectangle(corner=(W2/2 + G2 + stub_x, -W/2, dielectric_h), x_size=cpw_L - stub_x, y_size=W)
  IO_Copper7 = circle(normal=Z, centre=(0, 0, dielectric_h), radius=W2 / 2)
  Center_2 = polyline(z=dielectric_h, xy: (0, W4/2) (W2/2 + G2 + stub_x + W, W3/2) (W2/2 + G2 + stub_x + W, -W3/2) (0, -W4/2) (0, W4/2), closed, covered)
  IO_Copper7.unite(Center_2)
  IO_Copper7.fillet(Vertices=Center.vertex(#109175, #109174) Radius=fillet_r2 Setback=0in)
  Stub6 = circle(normal=Z, centre=(0in, 0in, dielectric_h), radius=W2/2 + G2 + stub_x + W5)
  Circle4 = circle(normal=Z, centre=(0in, 0in, dielectric_h), radius=W2/2 + stub_x + G2)
  Rectangle18 = rectangle(corner=(-(W2/2 + G2 + stub_x + W5), 0in, dielectric_h), x_size=W2 + 2 * (G2 + stub_x + W5), y_size=W2/2 + G2 + stub_x + W5)
  Rectangle18.rotate(axis=Z, angle=stub_theta)
  Rectangle15_4 = Rectangle18.duplicate_mirror(point=(0in, 0in, 0in), normal=(0in, 1in, 0in))
  Stub6.subtract(Circle4, Rectangle18, Rectangle15_4)
  Center.unite(IO_Copper7, Stub6)
  IO_Copper8 = circle(normal=Z, centre=(0, 0, dielectric_h), radius=W2 / 2 + G2)
  Stub7 = circle(normal=Z, centre=(0in, 0in, dielectric_h), radius=W2/2 + G2 + stub_x + W5)
  Rectangle19 = rectangle(corner=(-(W2/2 + G2 + stub_x + W5), 0in, dielectric_h), x_size=W2 + 2 * (G2 + stub_x + W5), y_size=W2/2 + G2 + stub_x + W5)
  Rectangle19.rotate(axis=Z, angle=stub_theta)
  Rectangle15_5 = Rectangle19.duplicate_mirror(point=(0in, 0in, 0in), normal=(0in, 1in, 0in))
  Stub7.subtract(Rectangle15_5, Rectangle19)
  Stub7.move_edges(MoveAlongNormalFlag=true OffsetDistance=G EdgesToMove=Gap.edge(#109251, #109252, 1 of 1))
  Transmission_Gap = cylinder(axis=Z, base_centre=(io_x-transmission_r, silicon_size/2, dielectric_h), radius=transmission_r + W/2 + G, height=copper_t)
  Box6 = box(corner=(-dielectric_d/2, silicon_size/2, dielectric_h), size=(dielectric_d, dielectric_d / 2, copper_t))
  Box7 = box(corner=(0, -dielectric_d/2, dielectric_h), size=(-dielectric_d / 2, dielectric_d, copper_t))
  Box7.rotate(axis=Z, angle=acos(silicon_size / transmission_r / 2))
  Cylinder3 = cylinder(axis=Z, base_centre=(io_x-transmission_r, silicon_size/2, dielectric_h), radius=transmission_r - W/2 -G, height=copper_t)
  Transmission_Gap.subtract(Box6, Box7, Cylinder3)
  Transmission_Gap_1 = Transmission_Gap.duplicate_around_axis(axis=Z, angle=180deg, total=2)
  Transmission_Gap.unite(Transmission_Gap_1)
  Transmission_Center = cylinder(axis=Z, base_centre=(io_x-transmission_r, silicon_size/2, dielectric_h), radius=transmission_r + W/2, height=copper_t)
  Box4 = box(corner=(-dielectric_d/2, silicon_size/2, dielectric_h), size=(dielectric_d, dielectric_d / 2, copper_t))
  Box5 = box(corner=(0, -dielectric_d/2, dielectric_h), size=(-dielectric_d / 2, dielectric_d, copper_t))
  Box5.rotate(axis=Z, angle=acos(silicon_size / transmission_r / 2))
  Cylinder2 = cylinder(axis=Z, base_centre=(io_x-transmission_r, silicon_size/2, dielectric_h), radius=transmission_r - W/2, height=copper_t)
  Transmission_Center.subtract(Box4, Box5, Cylinder2)
  Transmission_Center_1 = Transmission_Center.duplicate_around_axis(axis=Z, angle=180deg, total=2)
  Transmission_Center.unite(Transmission_Center_1)
  Transmission_Gap.subtract(Transmission_Center)
  Gap.move_edges(MoveAlongNormalFlag=true OffsetDistance=G EdgesToMove=Gap.edge(1 of 4, 3 of 4, 4 of 4))
  Gap.unite(IO_Copper8, Stub7)
  Gap.subtract(Center)
  Gap.thicken(copper_t)
  Gap.rotate(axis=Z, angle=-90deg)
  Gap.move(io_x, io_y, 0in)
  via_cpw_r_22 = cylinder(axis=Z, base_centre=(io_x + (W/2 + G + via_gap), 5mm, 0in), radius=via_d / 2, height=dielectric_h)
  via_cpw_l.unite(via_cpw_l_1..via_cpw_l_5, via_cpw_l_10, via_cpw_l_11)
  via_cpw_r_0 = cylinder(axis=Z, base_centre=(3.8mm, 11.1mm, 0mm), radius=via_d / 2, height=dielectric_h)
  via_cpw_r.unite(via_cpw_r_0..via_cpw_r_14, via_cpw_r_20, via_cpw_r_21, via_cpw_r_22)
  via_cpw_l.unite(via_cpw_r)
  via_cpw_l_12 = via_cpw_l.duplicate_mirror(point=(0in, 0in, 0in), normal=(1in, 0in, 0in))
  via_cpw_l.unite(via_cpw_l_12)
  via_cpw_l_13, via_cpw_l_14, via_cpw_l_15 = via_cpw_l.duplicate_around_axis(axis=Z, angle=90deg, total=4)
  via_cpw_l.unite(via_cpw_l_13, via_cpw_l_14, via_cpw_l_15, via_cpw_t)
  TMM6.subtract(via_cpw_l)
  TMM6.subtract(Center_Conductor_2_3, Center_Conductor_5, LD_PTFE_2_3, LD_PTFE_5, Outer_Conductor_1_3, Outer_Conductor_4)
  Gap.fillet(Edges=Gap.edge(#110082, #110087, #110079, #110068, #110075, #110072) Radius=fillet Setback=0in)
  Gap_1 = Gap.duplicate_around_axis(axis=Z, angle=180deg, total=2)
  Gap.unite(Gap_1, Transmission_Gap)
  Copper [copper] = cylinder(axis=Z, base_centre=(0in, 0in, dielectric_h), radius=dielectric_d / 2, height=copper_t)
  Pocket1 [non-model] = rectangle(corner=(-silicon_size/2, -silicon_size/2, dielectric_h), x_size=silicon_size, y_size=silicon_size)
  Pocket1.thicken(copper_t)
  Post_Holes1 = cylinder(axis=Z, base_centre=(0in, post_r1, -copper_t), radius=post_hole_size / 2, height=dielectric_h + 2*copper_t)
  Post1_4, Post1_5, Post1_6 = Post_Holes1.duplicate_around_axis(axis=Z, angle=90deg, total=4)
  Post6 = cylinder(axis=Z, base_centre=(post_r2 / sqrt(2), post_r2 / sqrt(2), -copper_t), radius=post_hole_size / 2, height=dielectric_h + 2*copper_t)
  Post2_4, Post2_5, Post2_6 = Post6.duplicate_around_axis(axis=Z, angle=90deg, total=4)
  Post_Holes1.unite(Post1_4, Post1_5, Post1_6, Post6, Post2_4, Post2_5, Post2_6)
  Copper.subtract(Post_Holes1)
  Copper.subtract(Gap)
  Center_Conductor_6 = Center_Conductor.copy()
  Center_Conductor_2_4 = Center_Conductor_2.copy()
  Copper.subtract(Center_Conductor_6, Center_Conductor_2_4)
boundaries and excitations:
  1: Wave Port Faces=LD_PTFE.face(2 of 3) NumModes=1 DeembedDist=0.1in Modes{Mode1{CharImp=Zpi}}
  2: Wave Port Faces=LD_PTFE_2.face(3 of 4) NumModes=1 DeembedDist=0.1in Modes{Mode1{CharImp=Zpi}}
setups:
  0_20GHz: HfssDriven AdaptMultipleFreqs MultipleAdaptiveFreqsSetup{Broadband{Low=100MHz High=20GHz}} MaxDeltaS=0.002 MaximumPasses=99 MinimumPasses=1 MinimumConvergedPasses=1 PercentRefinement=30 BasisOrder=1 PortAccuracy=2
    sweep Sweep: 0.1GHz to 20GHz, 451 points; Type=Interpolating InterpTolerance=0.5 InterpMaxSolns=250 InterpUsePortImped=false PassivityErrorTolerance=0.0001
  4_8GHz: HfssDriven AdaptMultipleFreqs MultipleAdaptiveFreqsSetup{Broadband{Low=4GHz High=8GHz}} MaxDeltaS=0.001 MaximumPasses=99 MinimumPasses=1 MinimumConvergedPasses=1 PercentRefinement=30 BasisOrder=1 PortAccuracy=0.2
    sweep Sweep: 4GHz to 8GHz, 401 points; Type=Interpolating InterpTolerance=0.5 InterpMaxSolns=250 InterpUsePortImped=false PassivityErrorTolerance=0.0001
  2_10GHz: HfssDriven AdaptMultipleFreqs MultipleAdaptiveFreqsSetup{Broadband{Low=2GHz High=10GHz}} MaxDeltaS=0.001 MaximumPasses=99 MinimumPasses=1 MinimumConvergedPasses=1 PercentRefinement=30 BasisOrder=1 PortAccuracy=2
    sweep Sweep: 2GHz to 10GHz step 0.01GHz; Type=Interpolating InterpTolerance=0.5 InterpMaxSolns=250 InterpUsePortImped=false PassivityErrorTolerance=0.0001
source amplitudes:
  1:1: 1W 0deg
  2:1: 0W 0deg
optimetrics:
  OptimizationSetup1: Optimization Optimizer="Pattern Search" AnalysisStopOptions{StopForNumIteration MaxNumIteration=100000 MinNumIteration=10} CostFuncNormType=L2 Acceptable_Cost=0 Noise=1e-99 UpdateDesignWhenDone
    vary G2: Min=0.355mm Max=1.5mm MinStep=0.001mm MaxStep=0.1mm MinFocus=0.355mm MaxFocus=1.065mm start=0.8mm
    vary W: Min=0.71mm Max=0.75mm MinStep=0.001mm MaxStep=0.01mm MinFocus=0.71mm MaxFocus=0.75mm
    vary W3: Min=0.25mm Max=0.75mm MinStep=0.001mm MaxStep=0.05mm MinFocus=0.25mm MaxFocus=0.75mm start=0.53mm
    vary stub_l: Min=0.525mm Max=1.575mm MinStep=0.001mm MaxStep=0.1mm MinFocus=0.525mm MaxFocus=1.575mm start=1mm
    vary stub_theta: Min=45deg Max=135deg MinStep=1deg MaxStep=10deg MinFocus=45deg MaxFocus=135deg start=90deg
    vary stub_x: Min=-0.1mm Max=0.2mm MinStep=0.001mm MaxStep=0.01mm MinFocus=0.054375mm MaxFocus=0.163125mm start=0.1mm
    vary stub_y: Min=2.3mm Max=2.7mm MinStep=0.001mm MaxStep=0.1mm MinFocus=1.3mm MaxFocus=3.9mm
    goal variance(deriv(dB(S(1,1)))) Minimize 0 weight 1 on 2_10GHz : Sweep at Freq 2GHz to 10GHz
reports:
  S Parameter Plot 1: dB(S(1,1)), dB(S(1,2)) vs Freq on 2_10GHz : Sweep
  S Parameter Plot 2: dB(S(1,1)), dB(S(2,1)) vs Freq on 0_20GHz : Sweep
